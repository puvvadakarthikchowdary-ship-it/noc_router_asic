* NGSPICE file created from noc_top.ext - technology: sky130A

* Black-box entry subcircuit for sky130_fd_sc_hd__fill_1 abstract view
.subckt sky130_fd_sc_hd__fill_1 VGND VNB VPB VPWR
.ends

* Black-box entry subcircuit for sky130_fd_sc_hd__inv_2 abstract view
.subckt sky130_fd_sc_hd__inv_2 A VGND VNB VPB VPWR Y
.ends

* Black-box entry subcircuit for sky130_fd_sc_hd__clkbuf_4 abstract view
.subckt sky130_fd_sc_hd__clkbuf_4 A VGND VNB VPB VPWR X
.ends

* Black-box entry subcircuit for sky130_fd_sc_hd__decap_4 abstract view
.subckt sky130_fd_sc_hd__decap_4 VGND VNB VPB VPWR
.ends

* Black-box entry subcircuit for sky130_fd_sc_hd__decap_8 abstract view
.subckt sky130_fd_sc_hd__decap_8 VGND VNB VPB VPWR
.ends

* Black-box entry subcircuit for sky130_fd_sc_hd__clkbuf_1 abstract view
.subckt sky130_fd_sc_hd__clkbuf_1 A VGND VNB VPB VPWR X
.ends

* Black-box entry subcircuit for sky130_fd_sc_hd__and2_1 abstract view
.subckt sky130_fd_sc_hd__and2_1 A B VGND VNB VPB VPWR X
.ends

* Black-box entry subcircuit for sky130_fd_sc_hd__or2_1 abstract view
.subckt sky130_fd_sc_hd__or2_1 A B VGND VNB VPB VPWR X
.ends

* Black-box entry subcircuit for sky130_fd_sc_hd__decap_3 abstract view
.subckt sky130_fd_sc_hd__decap_3 VGND VNB VPB VPWR
.ends

* Black-box entry subcircuit for sky130_fd_sc_hd__nand2_1 abstract view
.subckt sky130_fd_sc_hd__nand2_1 A B VGND VNB VPB VPWR Y
.ends

* Black-box entry subcircuit for sky130_fd_sc_hd__fill_2 abstract view
.subckt sky130_fd_sc_hd__fill_2 VGND VNB VPB VPWR
.ends

* Black-box entry subcircuit for sky130_fd_sc_hd__clkbuf_16 abstract view
.subckt sky130_fd_sc_hd__clkbuf_16 A VGND VNB VPB VPWR X
.ends

* Black-box entry subcircuit for sky130_fd_sc_hd__xor2_1 abstract view
.subckt sky130_fd_sc_hd__xor2_1 A B VGND VNB VPB VPWR X
.ends

* Black-box entry subcircuit for sky130_ef_sc_hd__decap_12 abstract view
.subckt sky130_ef_sc_hd__decap_12 VPWR VGND VPB VNB
.ends

* Black-box entry subcircuit for sky130_fd_sc_hd__and4_1 abstract view
.subckt sky130_fd_sc_hd__and4_1 A B C D VGND VNB VPB VPWR X
.ends

* Black-box entry subcircuit for sky130_fd_sc_hd__tapvpwrvgnd_1 abstract view
.subckt sky130_fd_sc_hd__tapvpwrvgnd_1 VGND VPWR
.ends

* Black-box entry subcircuit for sky130_fd_sc_hd__dfrtp_1 abstract view
.subckt sky130_fd_sc_hd__dfrtp_1 CLK D RESET_B VGND VNB VPB VPWR Q
.ends

* Black-box entry subcircuit for sky130_fd_sc_hd__nor2_1 abstract view
.subckt sky130_fd_sc_hd__nor2_1 A B VGND VNB VPB VPWR Y
.ends

* Black-box entry subcircuit for sky130_fd_sc_hd__dlygate4sd3_1 abstract view
.subckt sky130_fd_sc_hd__dlygate4sd3_1 A VGND VNB VPB VPWR X
.ends

* Black-box entry subcircuit for sky130_fd_sc_hd__a21oi_1 abstract view
.subckt sky130_fd_sc_hd__a21oi_1 A1 A2 B1 VGND VNB VPB VPWR Y
.ends

* Black-box entry subcircuit for sky130_fd_sc_hd__and3_1 abstract view
.subckt sky130_fd_sc_hd__and3_1 A B C VGND VNB VPB VPWR X
.ends

* Black-box entry subcircuit for sky130_fd_sc_hd__and2b_1 abstract view
.subckt sky130_fd_sc_hd__and2b_1 A_N B VGND VNB VPB VPWR X
.ends

* Black-box entry subcircuit for sky130_fd_sc_hd__a31o_1 abstract view
.subckt sky130_fd_sc_hd__a31o_1 A1 A2 A3 B1 VGND VNB VPB VPWR X
.ends

* Black-box entry subcircuit for sky130_fd_sc_hd__and4_2 abstract view
.subckt sky130_fd_sc_hd__and4_2 A B C D VGND VNB VPB VPWR X
.ends

* Black-box entry subcircuit for sky130_fd_sc_hd__xnor2_1 abstract view
.subckt sky130_fd_sc_hd__xnor2_1 A B VGND VNB VPB VPWR Y
.ends

* Black-box entry subcircuit for sky130_fd_sc_hd__buf_2 abstract view
.subckt sky130_fd_sc_hd__buf_2 A VGND VNB VPB VPWR X
.ends

.subckt noc_top VGND VPWR clk debug_out[0] debug_out[1] debug_out[2] debug_out[3]
+ debug_out[4] debug_out[5] debug_out[6] debug_out[7] rst
XFILLER_0_9_27 VGND VGND VPWR VPWR sky130_fd_sc_hd__fill_1
X_49_ net1 VGND VGND VPWR VPWR _15_ sky130_fd_sc_hd__inv_2
Xoutput7 net7 VGND VGND VPWR VPWR debug_out[5] sky130_fd_sc_hd__clkbuf_4
X_48_ net1 VGND VGND VPWR VPWR _14_ sky130_fd_sc_hd__inv_2
Xoutput8 net8 VGND VGND VPWR VPWR debug_out[6] sky130_fd_sc_hd__clkbuf_4
XFILLER_0_6_29 VGND VGND VPWR VPWR sky130_fd_sc_hd__fill_1
X_47_ net1 VGND VGND VPWR VPWR _13_ sky130_fd_sc_hd__inv_2
XFILLER_0_1_52 VGND VGND VPWR VPWR sky130_fd_sc_hd__decap_4
Xoutput9 net9 VGND VGND VPWR VPWR debug_out[7] sky130_fd_sc_hd__clkbuf_4
XFILLER_0_9_3 VGND VGND VPWR VPWR sky130_fd_sc_hd__decap_4
XFILLER_0_9_19 VGND VGND VPWR VPWR sky130_fd_sc_hd__decap_8
X_46_ net1 VGND VGND VPWR VPWR _12_ sky130_fd_sc_hd__inv_2
X_29_ _18_ VGND VGND VPWR VPWR _01_ sky130_fd_sc_hd__clkbuf_1
X_45_ net1 VGND VGND VPWR VPWR _11_ sky130_fd_sc_hd__inv_2
X_28_ _16_ _17_ VGND VGND VPWR VPWR _18_ sky130_fd_sc_hd__and2_1
X_44_ net1 VGND VGND VPWR VPWR _10_ sky130_fd_sc_hd__inv_2
X_27_ net2 net3 VGND VGND VPWR VPWR _17_ sky130_fd_sc_hd__or2_1
XPHY_0 VGND VGND VPWR VPWR sky130_fd_sc_hd__decap_3
XFILLER_0_4_55 VGND VGND VPWR VPWR sky130_fd_sc_hd__decap_3
X_26_ net2 net3 VGND VGND VPWR VPWR _16_ sky130_fd_sc_hd__nand2_1
X_43_ net1 VGND VGND VPWR VPWR _09_ sky130_fd_sc_hd__inv_2
XPHY_1 VGND VGND VPWR VPWR sky130_fd_sc_hd__decap_3
X_42_ net1 VGND VGND VPWR VPWR _08_ sky130_fd_sc_hd__inv_2
XFILLER_0_4_23 VGND VGND VPWR VPWR sky130_fd_sc_hd__fill_2
XFILLER_0_1_57 VGND VGND VPWR VPWR sky130_fd_sc_hd__fill_1
X_25_ net10 VGND VGND VPWR VPWR _00_ sky130_fd_sc_hd__inv_2
XPHY_2 VGND VGND VPWR VPWR sky130_fd_sc_hd__decap_3
Xclkbuf_0_clk clk VGND VGND VPWR VPWR clknet_0_clk sky130_fd_sc_hd__clkbuf_16
X_41_ net11 _24_ VGND VGND VPWR VPWR _07_ sky130_fd_sc_hd__xor2_1
XPHY_3 VGND VGND VPWR VPWR sky130_fd_sc_hd__decap_3
XFILLER_0_7_57 VGND VGND VPWR VPWR sky130_fd_sc_hd__fill_1
XFILLER_0_5_3 VPWR VGND VPWR VGND sky130_ef_sc_hd__decap_12
X_40_ net6 net7 net8 _19_ VGND VGND VPWR VPWR _24_ sky130_fd_sc_hd__and4_1
XPHY_4 VGND VGND VPWR VPWR sky130_fd_sc_hd__decap_3
XFILLER_0_4_15 VGND VGND VPWR VPWR sky130_fd_sc_hd__decap_8
XPHY_5 VGND VGND VPWR VPWR sky130_fd_sc_hd__decap_3
XFILLER_0_1_28 VGND VGND VPWR VPWR sky130_fd_sc_hd__decap_4
XPHY_6 VGND VGND VPWR VPWR sky130_fd_sc_hd__decap_3
Xinput1 rst VGND VGND VPWR VPWR net1 sky130_fd_sc_hd__clkbuf_4
XPHY_7 VGND VGND VPWR VPWR sky130_fd_sc_hd__decap_3
XPHY_8 VGND VGND VPWR VPWR sky130_fd_sc_hd__decap_3
XPHY_9 VGND VGND VPWR VPWR sky130_fd_sc_hd__decap_3
XFILLER_0_1_3 VGND VGND VPWR VPWR sky130_fd_sc_hd__fill_2
XTAP_30 VGND VPWR sky130_fd_sc_hd__tapvpwrvgnd_1
XFILLER_0_5_44 VGND VGND VPWR VPWR sky130_fd_sc_hd__decap_3
X_57_ clknet_1_1__leaf_clk _07_ _15_ VGND VGND VPWR VPWR net9 sky130_fd_sc_hd__dfrtp_1
XFILLER_0_8_44 VGND VGND VPWR VPWR sky130_fd_sc_hd__fill_1
XTAP_31 VGND VPWR sky130_fd_sc_hd__tapvpwrvgnd_1
XTAP_20 VGND VPWR sky130_fd_sc_hd__tapvpwrvgnd_1
X_56_ clknet_1_1__leaf_clk _06_ _14_ VGND VGND VPWR VPWR net8 sky130_fd_sc_hd__dfrtp_1
Xclkbuf_1_0__f_clk clknet_0_clk VGND VGND VPWR VPWR clknet_1_0__leaf_clk sky130_fd_sc_hd__clkbuf_16
X_39_ net12 _22_ VGND VGND VPWR VPWR _06_ sky130_fd_sc_hd__xor2_1
XFILLER_0_8_56 VGND VGND VPWR VPWR sky130_fd_sc_hd__fill_2
XTAP_21 VGND VPWR sky130_fd_sc_hd__tapvpwrvgnd_1
XFILLER_0_5_57 VGND VGND VPWR VPWR sky130_fd_sc_hd__fill_1
XFILLER_0_2_25 VGND VGND VPWR VPWR sky130_fd_sc_hd__decap_3
X_55_ clknet_1_1__leaf_clk _05_ _13_ VGND VGND VPWR VPWR net7 sky130_fd_sc_hd__dfrtp_1
X_38_ _22_ _23_ VGND VGND VPWR VPWR _05_ sky130_fd_sc_hd__nor2_1
Xhold1 net2 VGND VGND VPWR VPWR net10 sky130_fd_sc_hd__dlygate4sd3_1
XFILLER_0_5_36 VGND VGND VPWR VPWR sky130_fd_sc_hd__decap_3
XTAP_22 VGND VPWR sky130_fd_sc_hd__tapvpwrvgnd_1
X_54_ clknet_1_1__leaf_clk _04_ _12_ VGND VGND VPWR VPWR net6 sky130_fd_sc_hd__dfrtp_1
X_37_ net14 _19_ net15 VGND VGND VPWR VPWR _23_ sky130_fd_sc_hd__a21oi_1
Xhold2 net9 VGND VGND VPWR VPWR net11 sky130_fd_sc_hd__dlygate4sd3_1
XTAP_23 VGND VPWR sky130_fd_sc_hd__tapvpwrvgnd_1
XFILLER_0_5_15 VGND VGND VPWR VPWR sky130_fd_sc_hd__fill_1
XFILLER_0_8_3 VGND VGND VPWR VPWR sky130_fd_sc_hd__fill_1
X_53_ clknet_1_0__leaf_clk _03_ _11_ VGND VGND VPWR VPWR net5 sky130_fd_sc_hd__dfrtp_1
X_36_ net6 net7 _19_ VGND VGND VPWR VPWR _22_ sky130_fd_sc_hd__and3_1
Xhold3 net8 VGND VGND VPWR VPWR net12 sky130_fd_sc_hd__dlygate4sd3_1
X_52_ clknet_1_0__leaf_clk _02_ _10_ VGND VGND VPWR VPWR net4 sky130_fd_sc_hd__dfrtp_1
XTAP_24 VGND VPWR sky130_fd_sc_hd__tapvpwrvgnd_1
X_35_ net14 _19_ VGND VGND VPWR VPWR _04_ sky130_fd_sc_hd__xor2_1
Xhold4 net4 VGND VGND VPWR VPWR net13 sky130_fd_sc_hd__dlygate4sd3_1
XTAP_25 VGND VPWR sky130_fd_sc_hd__tapvpwrvgnd_1
X_51_ clknet_1_0__leaf_clk _01_ _09_ VGND VGND VPWR VPWR net3 sky130_fd_sc_hd__dfrtp_1
XFILLER_0_2_29 VGND VGND VPWR VPWR sky130_fd_sc_hd__fill_2
X_34_ _21_ VGND VGND VPWR VPWR _03_ sky130_fd_sc_hd__clkbuf_1
Xhold5 net6 VGND VGND VPWR VPWR net14 sky130_fd_sc_hd__dlygate4sd3_1
XPHY_10 VGND VGND VPWR VPWR sky130_fd_sc_hd__decap_3
XTAP_26 VGND VPWR sky130_fd_sc_hd__tapvpwrvgnd_1
XFILLER_0_6_3 VGND VGND VPWR VPWR sky130_fd_sc_hd__fill_1
X_50_ clknet_1_0__leaf_clk _00_ _08_ VGND VGND VPWR VPWR net2 sky130_fd_sc_hd__dfrtp_1
X_33_ _19_ _20_ VGND VGND VPWR VPWR _21_ sky130_fd_sc_hd__and2b_1
Xhold6 net7 VGND VGND VPWR VPWR net15 sky130_fd_sc_hd__dlygate4sd3_1
Xclkbuf_1_1__f_clk clknet_0_clk VGND VGND VPWR VPWR clknet_1_1__leaf_clk sky130_fd_sc_hd__clkbuf_16
XTAP_27 VGND VPWR sky130_fd_sc_hd__tapvpwrvgnd_1
XPHY_11 VGND VGND VPWR VPWR sky130_fd_sc_hd__decap_3
X_32_ net2 net3 net4 net5 VGND VGND VPWR VPWR _20_ sky130_fd_sc_hd__a31o_1
XPHY_12 VGND VGND VPWR VPWR sky130_fd_sc_hd__decap_3
XTAP_28 VGND VPWR sky130_fd_sc_hd__tapvpwrvgnd_1
X_31_ net2 net3 net4 net5 VGND VGND VPWR VPWR _19_ sky130_fd_sc_hd__and4_2
XFILLER_0_4_3 VPWR VGND VPWR VGND sky130_ef_sc_hd__decap_12
XPHY_13 VGND VGND VPWR VPWR sky130_fd_sc_hd__decap_3
XTAP_29 VGND VPWR sky130_fd_sc_hd__tapvpwrvgnd_1
X_30_ net13 _16_ VGND VGND VPWR VPWR _02_ sky130_fd_sc_hd__xnor2_1
XPHY_14 VGND VGND VPWR VPWR sky130_fd_sc_hd__decap_3
XFILLER_0_3_55 VGND VGND VPWR VPWR sky130_fd_sc_hd__fill_1
XFILLER_0_9_32 VGND VGND VPWR VPWR sky130_fd_sc_hd__decap_8
XPHY_15 VGND VGND VPWR VPWR sky130_fd_sc_hd__decap_3
XFILLER_0_0_57 VGND VGND VPWR VPWR sky130_fd_sc_hd__fill_1
Xoutput2 net2 VGND VGND VPWR VPWR debug_out[0] sky130_fd_sc_hd__clkbuf_4
XFILLER_0_2_3 VGND VGND VPWR VPWR sky130_fd_sc_hd__fill_2
XPHY_16 VGND VGND VPWR VPWR sky130_fd_sc_hd__decap_3
XFILLER_0_3_57 VGND VGND VPWR VPWR sky130_fd_sc_hd__fill_1
XPHY_17 VGND VGND VPWR VPWR sky130_fd_sc_hd__decap_3
Xoutput3 net3 VGND VGND VPWR VPWR debug_out[1] sky130_fd_sc_hd__buf_2
XFILLER_0_9_57 VGND VGND VPWR VPWR sky130_fd_sc_hd__fill_1
XPHY_18 VGND VGND VPWR VPWR sky130_fd_sc_hd__decap_3
Xoutput4 net4 VGND VGND VPWR VPWR debug_out[2] sky130_fd_sc_hd__clkbuf_4
XPHY_19 VGND VGND VPWR VPWR sky130_fd_sc_hd__decap_3
Xoutput5 net5 VGND VGND VPWR VPWR debug_out[3] sky130_fd_sc_hd__clkbuf_4
XFILLER_0_9_48 VGND VGND VPWR VPWR sky130_fd_sc_hd__decap_8
Xoutput6 net6 VGND VGND VPWR VPWR debug_out[4] sky130_fd_sc_hd__clkbuf_4
XFILLER_0_6_27 VGND VGND VPWR VPWR sky130_fd_sc_hd__fill_1
.ends
